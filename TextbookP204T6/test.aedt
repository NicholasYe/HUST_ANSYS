# Ansys Electronics Desktop project, version 2022.1
materials:
  vacuum: permittivity=1

design Maxwell2DDesign1 (Maxwell 2D, Electrostatic, XY geometry, model units mm)
geometry:
  Rectangle1 [vacuum] = rectangle(corner=(0mm, 0mm, 0mm), x_size=1000mm, y_size=1000mm)
  Region [vacuum] = region(percentage_offset=0 on all sides)
boundaries and excitations:
  Voltage1: Voltage Edges=Rectangle1.edge(y opposite corner) Value=100*sin(3.14*X) CoordinateSystem=Global
  Voltage2: Voltage Edges=Region.edge(3 of 4, 2 of 4, 1 of 4) Value=0V
parameters:
  Matrix1: Matrix Voltage1: NumberOfTurns=1
mesh:
  initial mesh: MeshMethod=AnsoftTAU
setups:
  Setup1: Electrostatic MaximumPasses=10 MinimumPasses=2 MinimumConvergedPasses=1 PercentRefinement=30 PercentError=1 NonLinearResidual=0.001
field plots:
  Voltage1: Voltage over Rectangle1, Region on Setup1 : LastAdaptive
